ADE simulation setup
Run mode: Single Run, Sweeps and Corners
Tests:
  EE746_DDP:neuron_tb:1: EE746_DDP/neuron_tb/schematic, simulator spectre
Global variables:
  VDD = 0.3
  VBIAS = 0
  VLK = 0
  VLK_AHP = 0
  VREST = 0
  VSET = 0
  VTHC = 20m
  ITHR = 1n
  IIN = 10n
  ITAU = 1n
