ADE simulation setup
Run mode: Single Run, Sweeps and Corners
Tests:
  EE746_DDP:COMP_tb:1: EE746_DDP/COMP_tb/schematic, simulator spectre
Global variables:
  VDD = 0
  VBIAS = 0
  VTHC = 0.1
